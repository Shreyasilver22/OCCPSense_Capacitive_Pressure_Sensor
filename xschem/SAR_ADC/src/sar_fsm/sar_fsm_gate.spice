* SPICE netlist generated by Yosys 0.9 (git sha1 1979e0b)

.SUBCKT _paramod_sar_logic_N_10_SAMPLE_CYCLES_4_DAC_SETTLE_CYCLES_3_INVERT_COMP_1'0 clk rst_n start comp sample comp_clk busy valid bp.9 bp.8 bp.7 bp.6 bp.5 bp.4 bp.3 bp.2 bp.1 bp.0 bn.9 bn.8 bn.7 bn.6 bn.5 bn.4 bn.3 bn.2 bn.1 bn.0 code.9 code.8 code.7 code.6 code.5 code.4 code.3 code.2 code.1 code.0
X0 bit_idx.1 1 gf180mcu_fd_sc_mcu7t5v0__clkinv_1
X1 bit_idx.2 2 gf180mcu_fd_sc_mcu7t5v0__clkinv_1
X2 comp_clk 3 gf180mcu_fd_sc_mcu7t5v0__clkinv_1
X3 state.2 4 gf180mcu_fd_sc_mcu7t5v0__clkinv_1
X4 count.2 5 gf180mcu_fd_sc_mcu7t5v0__clkinv_1
X5 count.3 6 gf180mcu_fd_sc_mcu7t5v0__clkinv_1
X6 count.4 7 gf180mcu_fd_sc_mcu7t5v0__clkinv_1
X7 count.5 8 gf180mcu_fd_sc_mcu7t5v0__clkinv_1
X8 count.6 9 gf180mcu_fd_sc_mcu7t5v0__clkinv_1
X9 bit_idx.3 10 gf180mcu_fd_sc_mcu7t5v0__clkinv_1
X10 bit_idx.0 11 gf180mcu_fd_sc_mcu7t5v0__clkinv_1
X11 code.1 12 gf180mcu_fd_sc_mcu7t5v0__clkinv_1
X12 code.2 13 gf180mcu_fd_sc_mcu7t5v0__clkinv_1
X13 start 14 gf180mcu_fd_sc_mcu7t5v0__clkinv_1
X14 code.0 15 gf180mcu_fd_sc_mcu7t5v0__clkinv_1
X15 count.1 16 gf180mcu_fd_sc_mcu7t5v0__clkinv_1
X16 bp.9 17 gf180mcu_fd_sc_mcu7t5v0__clkinv_1
X17 bp.8 18 gf180mcu_fd_sc_mcu7t5v0__clkinv_1
X18 bp.0 19 gf180mcu_fd_sc_mcu7t5v0__clkinv_1
X19 bn.8 20 gf180mcu_fd_sc_mcu7t5v0__clkinv_1
X20 bn.6 21 gf180mcu_fd_sc_mcu7t5v0__clkinv_1
X21 bn.5 22 gf180mcu_fd_sc_mcu7t5v0__clkinv_1
X22 bn.4 23 gf180mcu_fd_sc_mcu7t5v0__clkinv_1
X23 bn.3 24 gf180mcu_fd_sc_mcu7t5v0__clkinv_1
X24 bn.2 25 gf180mcu_fd_sc_mcu7t5v0__clkinv_1
X25 bn.1 26 gf180mcu_fd_sc_mcu7t5v0__clkinv_1
X26 bn.0 27 gf180mcu_fd_sc_mcu7t5v0__clkinv_1
X27 code.7 28 gf180mcu_fd_sc_mcu7t5v0__clkinv_1
X28 code.6 29 gf180mcu_fd_sc_mcu7t5v0__clkinv_1
X29 code.5 30 gf180mcu_fd_sc_mcu7t5v0__clkinv_1
X30 code.4 31 gf180mcu_fd_sc_mcu7t5v0__clkinv_1
X31 code.3 32 gf180mcu_fd_sc_mcu7t5v0__clkinv_1
X32 busy 33 gf180mcu_fd_sc_mcu7t5v0__clkinv_1
X33 count.2 count.3 34 gf180mcu_fd_sc_mcu7t5v0__or2_1
X34 count.4 count.5 35 count.6 count.7 gf180mcu_fd_sc_mcu7t5v0__or4_1
X35 count.0 16 36 34 35 gf180mcu_fd_sc_mcu7t5v0__or4_1
X36 state.2 36 37 gf180mcu_fd_sc_mcu7t5v0__nand2_1
X37 count.0 count.1 38 gf180mcu_fd_sc_mcu7t5v0__nand2_1
X38 34 35 38 39 gf180mcu_fd_sc_mcu7t5v0__nor3_1
X39 state.3 39 40 gf180mcu_fd_sc_mcu7t5v0__nand2_1
X40 bit_idx.1 bit_idx.0 41 gf180mcu_fd_sc_mcu7t5v0__nor2_1
X41 bit_idx.2 bit_idx.3 42 gf180mcu_fd_sc_mcu7t5v0__nor2_1
X42 bit_idx.1 bit_idx.2 bit_idx.0 43 gf180mcu_fd_sc_mcu7t5v0__nor3_1
X43 10 43 44 gf180mcu_fd_sc_mcu7t5v0__nand2_1
X44 comp_clk 44 45 gf180mcu_fd_sc_mcu7t5v0__nand2_1
X45 37 40 45 46 gf180mcu_fd_sc_mcu7t5v0__nand3_1
X46 state.0 start 47 gf180mcu_fd_sc_mcu7t5v0__nand2_1
X47 state.3 34 35 38 48 gf180mcu_fd_sc_mcu7t5v0__oai31_1
X48 47 48 49 gf180mcu_fd_sc_mcu7t5v0__nand2_1
X49 state.0 14 50 gf180mcu_fd_sc_mcu7t5v0__and2_1
X50 state.4 50 51 gf180mcu_fd_sc_mcu7t5v0__or2_1
X51 state.0 state.3 52 gf180mcu_fd_sc_mcu7t5v0__nor2_1
X52 comp_clk 50 52 53 gf180mcu_fd_sc_mcu7t5v0__nor3_1
X53 bit_idx.1 bit_idx.2 10 11 54 gf180mcu_fd_sc_mcu7t5v0__nor4_1
X54 1 2 bit_idx.3 bit_idx.0 55 gf180mcu_fd_sc_mcu7t5v0__nand4_1
X55 3 comp 55 56.9 53 17 gf180mcu_fd_sc_mcu7t5v0__oai32_1
X56 comp_clk bit_idx.3 43 57 gf180mcu_fd_sc_mcu7t5v0__nand3_1
X57 comp 57 58 gf180mcu_fd_sc_mcu7t5v0__or2_1
X58 53 18 58 56.8 gf180mcu_fd_sc_mcu7t5v0__aoi21_1
X59 bit_idx.1 bit_idx.0 59 gf180mcu_fd_sc_mcu7t5v0__nand2_1
X60 2 bit_idx.3 59 60 gf180mcu_fd_sc_mcu7t5v0__nor3_1
X61 3 comp 61 gf180mcu_fd_sc_mcu7t5v0__nor2_1
X62 bp.7 60 61 62 gf180mcu_fd_sc_mcu7t5v0__aoi21_1
X63 53 62 56.7 gf180mcu_fd_sc_mcu7t5v0__nor2_1
X64 1 2 bit_idx.3 bit_idx.0 63 gf180mcu_fd_sc_mcu7t5v0__nor4_1
X65 bit_idx.1 bit_idx.2 10 11 64 gf180mcu_fd_sc_mcu7t5v0__nand4_1
X66 bp.6 61 63 65 gf180mcu_fd_sc_mcu7t5v0__aoi21_1
X67 53 65 56.6 gf180mcu_fd_sc_mcu7t5v0__nor2_1
X68 bit_idx.1 2 bit_idx.3 11 66 gf180mcu_fd_sc_mcu7t5v0__nor4_1
X69 1 bit_idx.2 10 bit_idx.0 67 gf180mcu_fd_sc_mcu7t5v0__nand4_1
X70 bp.5 61 66 68 gf180mcu_fd_sc_mcu7t5v0__aoi21_1
X71 53 68 56.5 gf180mcu_fd_sc_mcu7t5v0__nor2_1
X72 bit_idx.2 10 69 41 gf180mcu_fd_sc_mcu7t5v0__and3_1
X73 bit_idx.2 10 41 70 gf180mcu_fd_sc_mcu7t5v0__nand3_1
X74 bp.4 61 69 71 gf180mcu_fd_sc_mcu7t5v0__aoi21_1
X75 53 71 56.4 gf180mcu_fd_sc_mcu7t5v0__nor2_1
X76 bit_idx.2 bit_idx.3 59 72 gf180mcu_fd_sc_mcu7t5v0__nor3_1
X77 bit_idx.1 bit_idx.0 42 73 gf180mcu_fd_sc_mcu7t5v0__nand3_1
X78 bp.3 61 72 74 gf180mcu_fd_sc_mcu7t5v0__aoi21_1
X79 53 74 56.3 gf180mcu_fd_sc_mcu7t5v0__nor2_1
X80 bit_idx.1 11 75 42 gf180mcu_fd_sc_mcu7t5v0__and3_1
X81 bit_idx.1 11 42 76 gf180mcu_fd_sc_mcu7t5v0__nand3_1
X82 bp.2 61 75 77 gf180mcu_fd_sc_mcu7t5v0__aoi21_1
X83 53 77 56.2 gf180mcu_fd_sc_mcu7t5v0__nor2_1
X84 1 bit_idx.0 78 42 gf180mcu_fd_sc_mcu7t5v0__and3_1
X85 1 bit_idx.0 42 79 gf180mcu_fd_sc_mcu7t5v0__nand3_1
X86 bp.1 61 78 80 gf180mcu_fd_sc_mcu7t5v0__aoi21_1
X87 53 80 56.1 gf180mcu_fd_sc_mcu7t5v0__nor2_1
X88 19 53 56.0 gf180mcu_fd_sc_mcu7t5v0__nor2_1
X89 comp_clk comp 81 gf180mcu_fd_sc_mcu7t5v0__and2_1
X90 bit_idx.3 43 81 82 gf180mcu_fd_sc_mcu7t5v0__nand3_1
X91 53 20 82 83.8 gf180mcu_fd_sc_mcu7t5v0__aoi21_1
X92 60 81 84 gf180mcu_fd_sc_mcu7t5v0__and2_1
X93 bn.7 60 81 85 gf180mcu_fd_sc_mcu7t5v0__aoi21_1
X94 53 85 83.7 gf180mcu_fd_sc_mcu7t5v0__nor2_1
X95 63 81 86 gf180mcu_fd_sc_mcu7t5v0__nand2_1
X96 53 21 86 83.6 gf180mcu_fd_sc_mcu7t5v0__aoi21_1
X97 66 81 87 gf180mcu_fd_sc_mcu7t5v0__nand2_1
X98 53 22 87 83.5 gf180mcu_fd_sc_mcu7t5v0__aoi21_1
X99 69 81 88 gf180mcu_fd_sc_mcu7t5v0__nand2_1
X100 53 23 88 83.4 gf180mcu_fd_sc_mcu7t5v0__aoi21_1
X101 72 81 89 gf180mcu_fd_sc_mcu7t5v0__nand2_1
X102 53 24 89 83.3 gf180mcu_fd_sc_mcu7t5v0__aoi21_1
X103 75 81 90 gf180mcu_fd_sc_mcu7t5v0__nand2_1
X104 53 25 90 83.2 gf180mcu_fd_sc_mcu7t5v0__aoi21_1
X105 78 81 91 gf180mcu_fd_sc_mcu7t5v0__nand2_1
X106 53 26 91 83.1 gf180mcu_fd_sc_mcu7t5v0__aoi21_1
X107 27 53 83.0 gf180mcu_fd_sc_mcu7t5v0__nor2_1
X108 3 bit_idx.3 43 92 gf180mcu_fd_sc_mcu7t5v0__aoi21_1
X109 state.0 3 93 gf180mcu_fd_sc_mcu7t5v0__nor2_1
X110 state.0 comp_clk 94 gf180mcu_fd_sc_mcu7t5v0__nor2_1
X111 state.0 95 3 14 gf180mcu_fd_sc_mcu7t5v0__mux2_1
X112 47 state.0 3 96 gf180mcu_fd_sc_mcu7t5v0__oai21_1
X113 code.8 92 95 97 gf180mcu_fd_sc_mcu7t5v0__oai21_1
X114 82 97 98.8 gf180mcu_fd_sc_mcu7t5v0__nand2_1
X115 comp_clk 2 bit_idx.3 59 99 gf180mcu_fd_sc_mcu7t5v0__oai31_1
X116 28 96 99 100 gf180mcu_fd_sc_mcu7t5v0__aoi21_1
X117 84 100 98.7 gf180mcu_fd_sc_mcu7t5v0__or2_1
X118 95 comp_clk 64 101 gf180mcu_fd_sc_mcu7t5v0__aoi21_1
X119 86 29 101 98.6 gf180mcu_fd_sc_mcu7t5v0__oai21_1
X120 95 comp_clk 67 102 gf180mcu_fd_sc_mcu7t5v0__aoi21_1
X121 87 30 102 98.5 gf180mcu_fd_sc_mcu7t5v0__oai21_1
X122 95 comp_clk 70 103 gf180mcu_fd_sc_mcu7t5v0__aoi21_1
X123 88 31 103 98.4 gf180mcu_fd_sc_mcu7t5v0__oai21_1
X124 95 comp_clk 73 104 gf180mcu_fd_sc_mcu7t5v0__aoi21_1
X125 89 32 104 98.3 gf180mcu_fd_sc_mcu7t5v0__oai21_1
X126 95 comp_clk 76 105 gf180mcu_fd_sc_mcu7t5v0__aoi21_1
X127 90 13 105 98.2 gf180mcu_fd_sc_mcu7t5v0__oai21_1
X128 95 comp_clk 79 106 gf180mcu_fd_sc_mcu7t5v0__aoi21_1
X129 91 12 106 98.1 gf180mcu_fd_sc_mcu7t5v0__oai21_1
X130 95 comp_clk 44 107 gf180mcu_fd_sc_mcu7t5v0__aoi21_1
X131 comp_clk 10 108 43 gf180mcu_fd_sc_mcu7t5v0__and3_1
X132 comp 108 109 gf180mcu_fd_sc_mcu7t5v0__nand2_1
X133 109 15 107 98.0 gf180mcu_fd_sc_mcu7t5v0__oai21_1
X134 bit_idx.0 state.0 start 110 gf180mcu_fd_sc_mcu7t5v0__aoi21_1
X135 bit_idx.0 93 111.0 110 45 gf180mcu_fd_sc_mcu7t5v0__aoi22_1
X136 bit_idx.1 bit_idx.0 112 gf180mcu_fd_sc_mcu7t5v0__xor2_1
X137 1 96 111.1 112 45 gf180mcu_fd_sc_mcu7t5v0__oai22_1
X138 3 41 113 gf180mcu_fd_sc_mcu7t5v0__nor2_1
X139 bit_idx.2 95 113 114 gf180mcu_fd_sc_mcu7t5v0__oai21_1
X140 57 114 111.2 gf180mcu_fd_sc_mcu7t5v0__nand2_1
X141 10 47 111.3 93 43 gf180mcu_fd_sc_mcu7t5v0__aoi22_1
X142 state.3 state.2 36 115 gf180mcu_fd_sc_mcu7t5v0__aoi21_1
X143 count.0 state.3 state.2 36 116 gf180mcu_fd_sc_mcu7t5v0__aoi211_1
X144 state.3 state.2 117 gf180mcu_fd_sc_mcu7t5v0__nor2_1
X145 state.0 14 118 94 117 gf180mcu_fd_sc_mcu7t5v0__aoi22_1
X146 108 50 94 117 119 gf180mcu_fd_sc_mcu7t5v0__aoi211_1
X147 116 count.0 119 120.0 gf180mcu_fd_sc_mcu7t5v0__aoi21_1
X148 count.0 16 121 gf180mcu_fd_sc_mcu7t5v0__xor2_1
X149 16 119 120.1 121 115 gf180mcu_fd_sc_mcu7t5v0__oai22_1
X150 count.2 count.0 count.1 122 gf180mcu_fd_sc_mcu7t5v0__aoi21_1
X151 4 48 123 gf180mcu_fd_sc_mcu7t5v0__and2_1
X152 5 38 124 gf180mcu_fd_sc_mcu7t5v0__nor2_1
X153 122 123 124 120.2 119 5 gf180mcu_fd_sc_mcu7t5v0__oai32_1
X154 count.3 124 125 gf180mcu_fd_sc_mcu7t5v0__nor2_1
X155 count.0 count.2 126 count.3 count.1 gf180mcu_fd_sc_mcu7t5v0__and4_1
X156 117 125 126 120.3 119 6 gf180mcu_fd_sc_mcu7t5v0__oai32_1
X157 count.4 126 127 gf180mcu_fd_sc_mcu7t5v0__nand2_1
X158 7 126 128 gf180mcu_fd_sc_mcu7t5v0__xor2_1
X159 7 119 120.4 128 117 gf180mcu_fd_sc_mcu7t5v0__oai22_1
X160 count.4 count.5 126 129 gf180mcu_fd_sc_mcu7t5v0__nand3_1
X161 count.5 127 130 gf180mcu_fd_sc_mcu7t5v0__xor2_1
X162 8 119 120.5 130 117 gf180mcu_fd_sc_mcu7t5v0__oai22_1
X163 count.4 count.5 131 count.6 126 gf180mcu_fd_sc_mcu7t5v0__and4_1
X164 118 3 44 132 117 131 gf180mcu_fd_sc_mcu7t5v0__oai221_1
X165 9 117 129 133 gf180mcu_fd_sc_mcu7t5v0__oai21_1
X166 132 133 120.6 gf180mcu_fd_sc_mcu7t5v0__and2_1
X167 9 117 129 134 gf180mcu_fd_sc_mcu7t5v0__nor3_1
X168 count.7 120.7 134 132 gf180mcu_fd_sc_mcu7t5v0__mux2_1
X169 code.9 54 135 gf180mcu_fd_sc_mcu7t5v0__nor2_1
X170 code.9 95 136 gf180mcu_fd_sc_mcu7t5v0__nand2_1
X171 comp_clk comp 55 137 gf180mcu_fd_sc_mcu7t5v0__oai21_1
X172 136 135 137 98.9 gf180mcu_fd_sc_mcu7t5v0__oai21_1
X173 sample 52 138 gf180mcu_fd_sc_mcu7t5v0__nand2_1
X174 48 138 139 gf180mcu_fd_sc_mcu7t5v0__nand2_1
X175 bn.9 54 81 140 gf180mcu_fd_sc_mcu7t5v0__aoi21_1
X176 53 140 83.9 gf180mcu_fd_sc_mcu7t5v0__nor2_1
X177 47 state.4 state.0 33 141 gf180mcu_fd_sc_mcu7t5v0__oai31_1
X178 4 36 142 gf180mcu_fd_sc_mcu7t5v0__nor2_1
X179 clk state.0 51 rst_n gf180mcu_fd_sc_mcu7t5v0__dffsnq_1
X180 clk comp_clk state.5 rst_n gf180mcu_fd_sc_mcu7t5v0__dffrnq_1
X181 clk state.2 46 rst_n gf180mcu_fd_sc_mcu7t5v0__dffrnq_1
X182 clk state.3 49 rst_n gf180mcu_fd_sc_mcu7t5v0__dffrnq_1
X183 clk state.4 108 rst_n gf180mcu_fd_sc_mcu7t5v0__dffrnq_1
X184 clk state.5 142 rst_n gf180mcu_fd_sc_mcu7t5v0__dffrnq_1
X185 clk busy 141 rst_n gf180mcu_fd_sc_mcu7t5v0__dffrnq_1
X186 clk valid state.4 rst_n gf180mcu_fd_sc_mcu7t5v0__dffrnq_1
X187 clk bp.0 56.0 rst_n gf180mcu_fd_sc_mcu7t5v0__dffrnq_1
X188 clk bp.1 56.1 rst_n gf180mcu_fd_sc_mcu7t5v0__dffrnq_1
X189 clk bp.2 56.2 rst_n gf180mcu_fd_sc_mcu7t5v0__dffrnq_1
X190 clk bp.3 56.3 rst_n gf180mcu_fd_sc_mcu7t5v0__dffrnq_1
X191 clk bp.4 56.4 rst_n gf180mcu_fd_sc_mcu7t5v0__dffrnq_1
X192 clk bp.5 56.5 rst_n gf180mcu_fd_sc_mcu7t5v0__dffrnq_1
X193 clk bp.6 56.6 rst_n gf180mcu_fd_sc_mcu7t5v0__dffrnq_1
X194 clk bp.7 56.7 rst_n gf180mcu_fd_sc_mcu7t5v0__dffrnq_1
X195 clk bp.8 56.8 rst_n gf180mcu_fd_sc_mcu7t5v0__dffrnq_1
X196 clk bp.9 56.9 rst_n gf180mcu_fd_sc_mcu7t5v0__dffrnq_1
X197 clk sample 139 rst_n gf180mcu_fd_sc_mcu7t5v0__dffrnq_1
X198 clk bn.0 83.0 rst_n gf180mcu_fd_sc_mcu7t5v0__dffrnq_1
X199 clk bn.1 83.1 rst_n gf180mcu_fd_sc_mcu7t5v0__dffrnq_1
X200 clk bn.2 83.2 rst_n gf180mcu_fd_sc_mcu7t5v0__dffrnq_1
X201 clk bn.3 83.3 rst_n gf180mcu_fd_sc_mcu7t5v0__dffrnq_1
X202 clk bn.4 83.4 rst_n gf180mcu_fd_sc_mcu7t5v0__dffrnq_1
X203 clk bn.5 83.5 rst_n gf180mcu_fd_sc_mcu7t5v0__dffrnq_1
X204 clk bn.6 83.6 rst_n gf180mcu_fd_sc_mcu7t5v0__dffrnq_1
X205 clk bn.7 83.7 rst_n gf180mcu_fd_sc_mcu7t5v0__dffrnq_1
X206 clk bn.8 83.8 rst_n gf180mcu_fd_sc_mcu7t5v0__dffrnq_1
X207 clk bn.9 83.9 rst_n gf180mcu_fd_sc_mcu7t5v0__dffrnq_1
X208 clk code.0 98.0 rst_n gf180mcu_fd_sc_mcu7t5v0__dffrnq_1
X209 clk code.1 98.1 rst_n gf180mcu_fd_sc_mcu7t5v0__dffrnq_1
X210 clk code.2 98.2 rst_n gf180mcu_fd_sc_mcu7t5v0__dffrnq_1
X211 clk code.3 98.3 rst_n gf180mcu_fd_sc_mcu7t5v0__dffrnq_1
X212 clk code.4 98.4 rst_n gf180mcu_fd_sc_mcu7t5v0__dffrnq_1
X213 clk code.5 98.5 rst_n gf180mcu_fd_sc_mcu7t5v0__dffrnq_1
X214 clk code.6 98.6 rst_n gf180mcu_fd_sc_mcu7t5v0__dffrnq_1
X215 clk code.7 98.7 rst_n gf180mcu_fd_sc_mcu7t5v0__dffrnq_1
X216 clk code.8 98.8 rst_n gf180mcu_fd_sc_mcu7t5v0__dffrnq_1
X217 clk code.9 98.9 rst_n gf180mcu_fd_sc_mcu7t5v0__dffrnq_1
X218 clk bit_idx.0 111.0 rst_n gf180mcu_fd_sc_mcu7t5v0__dffsnq_1
X219 clk bit_idx.1 111.1 rst_n gf180mcu_fd_sc_mcu7t5v0__dffrnq_1
X220 clk bit_idx.2 111.2 rst_n gf180mcu_fd_sc_mcu7t5v0__dffrnq_1
X221 clk bit_idx.3 111.3 rst_n gf180mcu_fd_sc_mcu7t5v0__dffsnq_1
X222 clk count.0 120.0 rst_n gf180mcu_fd_sc_mcu7t5v0__dffrnq_1
X223 clk count.1 120.1 rst_n gf180mcu_fd_sc_mcu7t5v0__dffrnq_1
X224 clk count.2 120.2 rst_n gf180mcu_fd_sc_mcu7t5v0__dffrnq_1
X225 clk count.3 120.3 rst_n gf180mcu_fd_sc_mcu7t5v0__dffrnq_1
X226 clk count.4 120.4 rst_n gf180mcu_fd_sc_mcu7t5v0__dffrnq_1
X227 clk count.5 120.5 rst_n gf180mcu_fd_sc_mcu7t5v0__dffrnq_1
X228 clk count.6 120.6 rst_n gf180mcu_fd_sc_mcu7t5v0__dffrnq_1
X229 clk count.7 120.7 rst_n gf180mcu_fd_sc_mcu7t5v0__dffrnq_1
V0 cmp_p_gt_n comp DC 0
V1 state.1 comp_clk DC 0
.ENDS _paramod_sar_logic_N_10_SAMPLE_CYCLES_4_DAC_SETTLE_CYCLES_3_INVERT_COMP_1'0

X0 clk rst_n start comp sample comp_clk busy valid bp.9 bp.8 bp.7 bp.6 bp.5 bp.4 bp.3 bp.2 bp.1 bp.0 bn.9 bn.8 bn.7 bn.6 bn.5 bn.4 bn.3 bn.2 bn.1 bn.0 code.9 code.8 code.7 code.6 code.5 code.4 code.3 code.2 code.1 code.0 _paramod_sar_logic_N_10_SAMPLE_CYCLES_4_DAC_SETTLE_CYCLES_3_INVERT_COMP_1'0
V0 bn0 bn.0 DC 0
V1 bn1 bn.1 DC 0
V2 bn2 bn.2 DC 0
V3 bn3 bn.3 DC 0
V4 bn4 bn.4 DC 0
V5 bn5 bn.5 DC 0
V6 bn6 bn.6 DC 0
V7 bn7 bn.7 DC 0
V8 bn8 bn.8 DC 0
V9 bn9 bn.9 DC 0
V10 bp0 bp.0 DC 0
V11 bp1 bp.1 DC 0
V12 bp2 bp.2 DC 0
V13 bp3 bp.3 DC 0
V14 bp4 bp.4 DC 0
V15 bp5 bp.5 DC 0
V16 bp6 bp.6 DC 0
V17 bp7 bp.7 DC 0
V18 bp8 bp.8 DC 0
V19 bp9 bp.9 DC 0
V20 code0 code.0 DC 0
V21 code1 code.1 DC 0
V22 code2 code.2 DC 0
V23 code3 code.3 DC 0
V24 code4 code.4 DC 0
V25 code5 code.5 DC 0
V26 code6 code.6 DC 0
V27 code7 code.7 DC 0
V28 code8 code.8 DC 0
V29 code9 code.9 DC 0

************************
* end of SPICE netlist *
************************
